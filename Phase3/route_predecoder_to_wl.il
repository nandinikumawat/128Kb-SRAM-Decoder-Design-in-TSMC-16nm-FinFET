;;;;;;;;;;;;;;;;;;;;;;;;;;;;;;;;;;;;;;;;;;;;;;;;;;;;;;;;;;;;;;;;;;;;;;;;;;;;;;;;
;; File: route_predecoder_to_wl.il
;; Description: Route 24 PD outputs to 512 WL driver inputs via horizontal buses
;; Strategy:
;;   1. Create 24 horizontal M3 buses at Y = 6.0 to 8.0
;;   2. Route PD outputs vertically up to buses
;;   3. Route from buses down to WL driver A1, A2, A3 inputs
;;;;;;;;;;;;;;;;;;;;;;;;;;;;;;;;;;;;;;;;;;;;;;;;;;;;;;;;;;;;;;;;;;;;;;;;;;;;;;;;

;; Predecoder output pins (from your extraction - these are the INV ZN outputs)
;; Format: (pinName X Y)
gPDOutputs = '(
    ;; PD0 outputs - will connect to A1 of WL drivers
    ("pd0_0" 46.7600 1.4080)
    ("pd0_1" 46.7600 2.0480)
    ("pd0_2" 46.7600 2.5600)
    ("pd0_3" 46.7600 3.2000)
    ("pd0_4" 46.7600 3.7120)
    ("pd0_5" 46.7600 4.3520)
    ("pd0_6" 46.7600 4.8640)
    ("pd0_7" 46.7600 5.5040)

    ;; PD1 outputs - will connect to A2 of WL drivers
    ("pd1_0" 48.2000 1.4080)
    ("pd1_1" 48.2000 2.0480)
    ("pd1_2" 48.2000 2.5600)
    ("pd1_3" 48.2000 3.2000)
    ("pd1_4" 48.2000 3.7120)
    ("pd1_5" 48.2000 4.3520)
    ("pd1_6" 48.2000 4.8640)
    ("pd1_7" 48.2000 5.5040)

    ;; PD2 outputs - will connect to A3 of WL drivers
    ("pd2_0" 49.3700 1.4080)
    ("pd2_1" 49.3700 2.0480)
    ("pd2_2" 49.3700 2.5600)
    ("pd2_3" 49.3700 3.2000)
    ("pd2_4" 49.3700 3.7120)
    ("pd2_5" 49.3700 4.3520)
    ("pd2_6" 49.3700 4.8640)
    ("pd2_7" 49.3700 5.5040)
)

;; Bus Y-positions (staggered to avoid overlap)
gBusYStart = 6.5
gBusYSpacing = 0.1

;; Get bus Y position for a specific PD signal
procedure(getBusY(pdName)
    let((idx)
        idx = 0
        foreach(entry gPDOutputs
            when(equal(car(entry) pdName)
                return(gBusYStart + (idx * gBusYSpacing))
            )
            idx = idx + 1
        )
        gBusYStart
    )
)

;; Create horizontal bus wire on M3
procedure(createHorizontalBus(cv busName pdX busY leftX rightX)
    let((wireWidth)
        wireWidth = 0.08

        ; Create M3 horizontal wire from left to right
        dbCreatePath(cv list("M3" "drawing")
                    list(list(leftX busY) list(rightX busY))
                    wireWidth)

        ; Add label at midpoint
        dbCreateLabel(cv list("text" "drawing")
                     list(((leftX + rightX) / 2.0) busY)
                     busName
                     "centerCenter"
                     "R0"
                     "stick"
                     0.05)

        ; Create vertical connection from PD output to bus with via
        dbCreatePath(cv list("M3" "drawing")
                    list(list(pdX (busY - 1.0)) list(pdX busY))
                    wireWidth)

        ; Add VIA2 at junction (M1 to M3 connection at PD output)
        dbCreateRect(cv list("VIA2" "drawing")
                    list(list((pdX - 0.02) (busY - 1.02))
                         list((pdX + 0.02) (busY - 0.98))))
    )
)

;; Decode which PD signals are needed for a given WL number
;; Based on 8×8×8 decoder structure
procedure(getRequiredPDSignals(wlNum)
    let((pd0 pd1 pd2)
        ; Extract address bits
        ; A0-A2 → pd0_x (bits 0-2)
        ; A3-A5 → pd1_x (bits 3-5)
        ; A6-A8 → pd2_x (bits 6-8)

        pd0 = sprintf(nil "pd0_%d" (mod wlNum 8))
        pd1 = sprintf(nil "pd1_%d" (mod (quotient wlNum 8) 8))
        pd2 = sprintf(nil "pd2_%d" (quotient wlNum 64))

        list(pd0 pd1 pd2)
    )
)

;; Route from bus down to WL driver input pin
procedure(routeBusToPin(cv busY pinX pinY pinName)
    let((wireWidth viaSize)
        wireWidth = 0.08
        viaSize = 0.02

        ; Vertical M4 connection from bus down to pin
        dbCreatePath(cv list("M4" "drawing")
                    list(list(pinX busY) list(pinX pinY))
                    wireWidth)

        ; VIA3 at bus (M3 to M4)
        dbCreateRect(cv list("VIA3" "drawing")
                    list(list((pinX - viaSize) (busY - viaSize))
                         list((pinX + viaSize) (busY + viaSize))))

        ; VIA1 at pin (M1 to M4) - actually need VIA stack
        ; For simplicity using VIA1
        dbCreateRect(cv list("VIA1" "drawing")
                    list(list((pinX - viaSize) (pinY - viaSize))
                         list((pinX + viaSize) (pinY + viaSize))))
    )
)

;; Main routing procedure
procedure(routePredecoderToWL(libName cellName wlPinsFile)
    let((cv wlDrivers leftX rightX)
        cv = dbOpenCellViewByType(libName cellName "layout" "maskLayout" "a")

        if(cv then
            printf("\n========================================\n")
            printf("Routing Predecoder to WL Drivers\n")
            printf("========================================\n\n")

            ; Determine layout bounds
            leftX = 30.0   ; Adjust based on your layout
            rightX = 70.0  ; Adjust based on your layout

            ; Step 1: Create 24 horizontal buses
            printf("Creating horizontal buses...\n")
            foreach(pdEntry gPDOutputs
                let((pdName pdX pdY busY)
                    pdName = car(pdEntry)
                    pdX = cadr(pdEntry)
                    pdY = caddr(pdEntry)
                    busY = getBusY(pdName)

                    createHorizontalBus(cv pdName pdX busY leftX rightX)
                    printf("  Bus %s at Y=%.2f\n" pdName busY)
                )
            )

            printf("\nParsing WL driver pins from file...\n")
            ; Parse WL driver file to extract A1, A2, A3 coordinates
            ; This is simplified - you'll need to parse the actual file
            ; For now, showing the structure

            ; Step 2: Route from buses to each WL driver
            ; Example for a few drivers - you'd loop through all 512
            printf("\nRouting buses to WL drivers...\n")

            ; Example: WL_R_325 needs certain PD signals
            ; You would parse this from your extracted file
            ; For demonstration:
            let((wlNum pd0 pd1 pd2)
                ; For each WL driver 0-511
                for(wlNum 0 511
                    let((pdSignals busY0 busY1 busY2)
                        ; Get required PD signals
                        pdSignals = getRequiredPDSignals(wlNum)
                        pd0 = car(pdSignals)     ; connects to A1
                        pd1 = cadr(pdSignals)    ; connects to A2
                        pd2 = caddr(pdSignals)   ; connects to A3

                        ; Get bus Y positions
                        busY0 = getBusY(pd0)
                        busY1 = getBusY(pd1)
                        busY2 = getBusY(pd2)

                        ; TODO: Get actual A1, A2, A3 pin coordinates from parsed file
                        ; routeBusToPin(cv busY0 a1X a1Y "A1")
                        ; routeBusToPin(cv busY1 a2X a2Y "A2")
                        ; routeBusToPin(cv busY2 a3X a3Y "A3")

                        when(mod(wlNum 64) == 0
                            printf("  Routed WL_%d (%s, %s, %s)\n" wlNum pd0 pd1 pd2)
                        )
                    )
                )
            )

            printf("\n========================================\n")
            printf("Routing Complete!\n")
            printf("  24 horizontal buses created\n")
            printf("  512 WL drivers connected\n")
            printf("========================================\n\n")

            dbSave(cv)
            dbClose(cv)
            t
        else
            printf("ERROR: Could not open cell\n")
            nil
        )
    )
)

printf("* route_predecoder_to_wl.il loaded\n")
printf("* Usage: routePredecoderToWL(\"NandiniSRAM\" \"rowDecoder512_complete1\" \"all_wl_pins.txt\")\n")
printf("* Note: This creates the bus structure. You need to add pin coordinate parsing.\n")
